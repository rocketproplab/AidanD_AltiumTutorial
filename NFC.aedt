# Ansys Electronics Desktop project, version 2020.2
materials:
  copper: conductivity=58000000
  Default
  FR4_epoxy: permittivity=4.6
  solder
  SolderMask: permittivity=3.8
  air: permittivity=1.0006 permeability=1.0000004
  vacuum: permittivity=1
  pec: conductivity=1e+30

design main (HFSS 3D Layout)
ports:
  Port1: Properties{Impedance=50ohm Magnitude=1V Phase=0deg Renormalize_Impedence="50ohm + 0i ohm" Renormalize Deembed_Distance=0mm Deembed Type=Circuit HFSS_Type=Circuit Orientation=Horizontal Layer_Alignment=Upper Horizontal_Extent_Factor=5 Vertical_Extent_Factor=3 PEC_Launch_Width=0mm Reference_Net=GND} Type=EdgePort CircuitPort
setups:
  HFSS Setup 1: SolveSetupType=HFSS PercentRefinementPerPass=30 MinNumberOfPasses=1 MinNumberOfConvergedPasses=1 Frequency=10GHz MeshSizeFactor=1.5 ViaNumSides=6 Style25DVia=Mesh
    sweep Sweep: LINC 10MHz 20MHz 201; FastSweep SAbsError=0.005 ZoPercentError=1 PassivityTolerance=0.0001 MaxSolutions=250 InterpUseSMatrix InterpUsePortImpedance InterpUseFullBasis MinSolvedFreq=0.01GHz MagMinThreshold=0.01
reports:
  S Parameter Plot 1: dB(S(Port1,Port1)) vs Freq on HFSS Setup 1 : Sweep
